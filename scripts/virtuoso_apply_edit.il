;;; ============================================================
;;; Virtuoso SKILL Script: Apply Fin Resize Edit Operations
;;;
;;; Generated by buffer_fin_resize MVP pipeline.
;;; Adapt layer names and cell references for your actual PDK.
;;;
;;; Usage in CIW:
;;;   load("virtuoso_apply_edit.il")
;;;   applyFinResize()
;;; ============================================================

procedure(applyFinResize()
  let((cv editOps)

    ;; Open the cell for editing
    ;; CHANGE THESE to match your actual library/cell/view:
    cv = dbOpenCellViewByType("YOUR_LIB" "INV_CELL" "layout" nil "a")

    unless(cv
      error("Could not open cell for editing")
    )

    printf("Applying fin resize edits...\n")

    ;; ============================================================
    ;; Edit Operations (from solver output)
    ;; Coordinates in nm — convert to your database units if needed
    ;; ============================================================

    ;; --- NMOS: Remove top fin (track 4) ---
    ;; FIN shape at bbox (0, 137, 108, 143) nm
    ;; In production: find the shape by layer + bbox overlap, then delete
    ;; _removeShapeByBBox(cv "FIN" 0:137 108:143)

    ;; --- NMOS: Shrink OD ---
    ;; Old: (0, 30, 108, 150) → New: (0, 30, 108, 125)
    ;; _resizeShapeByBBox(cv "OD" 0:30 108:150  0:30 108:125)

    ;; --- NMOS: Shorten source LI bar ---
    ;; Old ortho [0→4] → New [0→3]
    ;; Physical: shorten y2 from ~150 to ~125
    ;; _resizeShapeByBBox(cv "LI" 18:35 35:150  18:35 35:125)

    ;; --- PMOS: Remove top fin (track 14) ---
    ;; _removeShapeByBBox(cv "FIN" 0:387 108:393)

    ;; --- PMOS: Shrink OD ---
    ;; _resizeShapeByBBox(cv "OD" 0:230 108:400  0:230 108:375)

    ;; --- PMOS: Shorten drain LI bar ---
    ;; _resizeShapeByBBox(cv "LI" 72:193 89:400  72:193 89:375)

    ;; ============================================================
    ;; Helper functions (implement based on your PDK/setup)
    ;; ============================================================

    ;; printf("Done. Run DRC to verify.\n")
    ;; dbSave(cv)
    ;; dbClose(cv)

  ) ; let
) ; procedure

;; ============================================================
;; Utility: find and delete a shape by layer + bbox overlap
;; ============================================================
procedure(_removeShapeByBBox(cv layerName llx_lly urx_ury)
  ;; Placeholder — implement shape search by bbox for your flow
  printf("  REMOVE %s at %L\n" layerName llx_lly:urx_ury)
)

;; ============================================================
;; Utility: resize a shape (change bbox)
;; ============================================================
procedure(_resizeShapeByBBox(cv layerName oldLL oldUR newLL newUR)
  ;; Placeholder — implement shape modification for your flow
  printf("  RESIZE %s: %L:%L → %L:%L\n" layerName oldLL oldUR newLL newUR)
)
