* Hierarchical dummy DRAM bank
.SUBCKT DRAMCELL WL BL CSL LIO VDD VSS
MSTOR BL WL VSS VSS NMOS W=1u L=20n
.ENDS DRAMCELL

.SUBCKT MAT WL BL CSL LIO VDD VSS
XCELL_R0_C0 WL BL CSL LIO VDD VSS DRAMCELL W=1u
XCELL_R0_C1 WL BL CSL LIO VDD VSS DRAMCELL W=1u
XCELL_R1_C1 WL BL CSL LIO VDD VSS DRAMCELL W=1u
XCELL_R2_C1 WL BL CSL LIO VDD VSS
+ DRAMCELL W=1u NF=2
XCELL_R2_C2 WL BL CSL LIO VDD VSS DRAMCELL W=1u
XCELL_R3_C1 WL BL CSL LIO VDD VSS DRAMCELL W=1u
.ENDS MAT

.SUBCKT ARRAY_SECTION WL BL CSL LIO VDD VSS
XMAT_0 WL BL CSL LIO VDD VSS MAT
.ENDS ARRAY_SECTION

.SUBCKT PERIPHERY WL BL CSL LIO VDD VSS
* Placeholder periphery model keeps the sample deck self-contained.
RWL_HOLD WL VSS 1e12
RBL_HOLD BL VSS 1e12
RCSL_HOLD CSL VSS 1e12
RLIO_HOLD LIO VSS 1e12
.ENDS PERIPHERY

.SUBCKT DRAM_BANK WL BL CSL LIO VDD VSS
XPERIPH0 WL BL CSL LIO VDD VSS PERIPHERY
XARRAY_0 WL BL CSL LIO VDD VSS ARRAY_SECTION
XARRAY_1 WL BL CSL LIO VDD VSS ARRAY_SECTION
XARRAY_2 WL BL CSL LIO VDD VSS ARRAY_SECTION
.ENDS DRAM_BANK

XTOP WL_G BL_G CSL_G LIO_G VDD 0 DRAM_BANK
